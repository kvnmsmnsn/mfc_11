** sch_path: /home/ttuser/Mfcs/mfc_11/xschem/mfc_11.sch
.subckt mfc_11 gate sbd
*.PININFO gate:I sbd:O
XM2 sbd gate sbd sbd sky130_fd_pr__nfet_01v8 L=0.3 W=0.84 nf=1 m=1
.ends
.end
